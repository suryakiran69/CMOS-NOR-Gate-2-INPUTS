ADE simulation setup
Run mode: Single Run, Sweeps and Corners
Tests:
  gates:nor_sim:1: gates/nor_sim/schematic, simulator spectre
